ADE simulation setup
Run mode: Single Run, Sweeps and Corners
Tests:
  Shifter_Shifter_8bit_sized_tb_1: Shifter/Shifter_8bit_sized_tb/schematic, simulator UltraSim
