;; shifter_metrics.ocn -- transient metrics for Shifter_8bit_sized
;;
;; Runs Shifter_8bit_sized_tb in Spectre (or re-reads an existing run) and reports,
;; per output Y0..Y7:  10-90% rise/fall slew, propagation delay;  and for the DUT:
;; average / peak power and total energy drawn from VDD.
;;
;; Usage (from the Cadence library's parent dir, where cds.lib lives):
;;   CIW:      load("Shifter/ocean/shifter_metrics.ocn")
;;   shell:    ocean -nograph -restore Shifter/ocean/shifter_metrics.ocn
;;
;; Results print to the log and are written to shmCsv.
;; Schematic only (no extraction): load shifter_metrics_schematic.ocn instead.
;;
;; Post-layout: run pex/run_pex.sh, then set shmPexNetlist to the tb_pex.scs it
;; prints. The same TB is simulated with the Calibre-extracted shifter (R+C+CC).

;; ---------------------------------------------------------------- config
shmLib    = "Shifter"
shmCell   = "Shifter_8bit_sized_tb"
shmDut    = "/I0"                 ; DUT instance in the TB schematic
shmVddNets = list("VDD" "vdd!" "VDD!" "vdd")  ; supply net candidates, first found wins
shmVddVal = nil                   ; set a number (e.g. 1.0) to skip reading VDD from the sim
;; path to pex/run/tb_pex.scs for post-layout, nil = schematic. A value set
;; before loading (e.g. by shifter_metrics_schematic.ocn) is kept.
unless(boundp('shmPexNetlist) shmPexNetlist = nil)
shmRunSim = t                     ; nil = only analyze shmResDir from a prior run
shmResDir = if(shmPexNetlist "./shifter_metrics_pex_sim" "./shifter_metrics_sim")
shmStop   = 10u
shmLo     = 10                    ; slew thresholds, % of VDD
shmHi     = 90
shmCsv    = if(shmPexNetlist "./shifter_metrics_pex.csv" "./shifter_metrics.csv")
shmModel  = "/courses/ee4321/tech/tsmc65/T-N65-CM-SP-018-K3_MOM/Base_PDK/PDK_CRN65GP_v1.0c_official_IC61_20101010/tsmcN65/../models/spectre/crn65gplus_2d5_lk_v1d0.scs"
shmOuts   = list("Y0" "Y1" "Y2" "Y3" "Y4" "Y5" "Y6" "Y7")
shmIns    = list("A0" "A1" "A2" "A3" "A4" "A5" "A6" "A7" "S0" "S1" "S2")

;; ---------------------------------------------------------------- helpers
;; Turn a number / list / waveform (from multiple=t measurements) into a list of numbers.
procedure(shmVals(w)
  cond(
    (null(w) nil)
    (numberp(w) list(w))
    (listp(w) w)
    (drIsWaveform(w)
      let((yv out)
        yv = drGetWaveformYVec(w)
        for(i 0 drVectorLength(yv)-1 out = cons(drGetElem(yv i) out))
        reverse(out)))
    (t nil)))

;; Evaluate a measurement, returning nil instead of erroring when there are no edges.
procedure(shmTry(expr)
  let((r) r = errset(evalstring(expr)) when(r car(r))))

procedure(shmMax(l)
  let((m) when(l m = car(l) foreach(x cdr(l) when(x > m m = x))) m))
procedure(shmAvg(l) when(l (apply('plus l) / length(l))))
procedure(shmFmt(x scale) if(x sprintf(nil "%.2f" x*scale) "-"))

;; Expression for a net's voltage: schematic names in schematic mode, raw
;; Spectre names when simulating a netlist file (post-layout).
procedure(shmV(n)
  if(shmPexNetlist sprintf(nil "getData(\"%s\")" n) sprintf(nil "VT(\"/%s\")" n)))

;; All crossing times of net at level v (any direction).
procedure(shmCross(net v)
  shmVals(shmTry(sprintf(nil "cross(%s %g 1 'either t \"cycle\")" shmV(net) v))))

shmDutName = car(last(parseString(shmDut "/")))

;; ---------------------------------------------------------------- simulate
if(shmRunSim then
  simulator('spectre)
  if(shmPexNetlist then
    unless(isFile(shmPexNetlist) error("shmPexNetlist not found: %s\n" shmPexNetlist))
    design(shmPexNetlist)
  else
    design(shmLib shmCell "schematic"))
  resultsDir(shmResDir)
  modelFile(list(shmModel "tt") list(shmModel "tt_bip") list(shmModel "tt_dio")
            list(shmModel "tt_dio_33"))
  analysis('tran ?stop shmStop ?errpreset "conservative")
  temp(27)
  ;; Naming signals in save() switches Spectre to "selected only", so every
  ;; voltage the script reads must be listed here too.
  foreach(n append(shmVddNets append(shmIns shmOuts))
    save('v if(shmPexNetlist n strcat("/" n))))
  if(shmPexNetlist
    errset(save('i strcat(shmDutName ":VDD")))
    errset(save('i strcat(shmDut "/VDD"))))
  ;; Fallbacks for power: all terminal currents + Spectre's own power signals.
  errset(saveOption('currents "all"))
  errset(saveOption('pwr "all"))
  run()
else
  openResults(shmResDir)
)
selectResult('tran)

;; ---------------------------------------------------------------- measure
;; VDD: explicit value > first supply net found > highest input-pulse level.
shmVdd = shmVddVal
unless(shmVdd
  foreach(n shmVddNets
    unless(shmVdd
      let((v) v = shmTry(sprintf(nil "ymax(%s)" shmV(n)))
        when(numberp(v) && v > 0.1
          shmVdd = v
          printf("VDD taken from net /%s\n" n))))))
unless(shmVdd
  let((vs)
    vs = setof(v mapcar(lambda((n) shmTry(sprintf(nil "ymax(%s)" shmV(n)))) shmIns)
               numberp(v))
    when(vs
      shmVdd = shmMax(vs)
      printf("No supply net saved; VDD taken from input high level\n"))))
unless(numberp(shmVdd)
  error("Could not determine VDD from %s (tried %L and the inputs). Set shmVddVal. \
Saved signals: %L\n" shmResDir shmVddNets errset(outputs())))
shmHalf = shmVdd / 2.0

;; Every input edge time, sorted -- used to attribute each output edge to its cause.
shmInEdges = sort(foreach(mapcan n shmIns copy(shmCross(n shmHalf))) 'lessp)

;; Delay of an output edge = time since the most recent input edge before it.
procedure(shmDelays(outTimes)
  let((res last)
    foreach(t0 outTimes
      last = nil
      foreach(ti shmInEdges when(ti <= t0 last = ti))
      when(last res = cons(t0 - last res)))
    res))

shmRows = nil
shmAllRise = nil  shmAllFall = nil  shmAllTpd = nil  shmEdges = 0
foreach(y shmOuts
  let((rise fall tpd)
    rise = shmVals(shmTry(sprintf(nil
             "riseTime(%s 0 nil %g nil %d %d t \"cycle\")" shmV(y) shmVdd shmLo shmHi)))
    fall = shmVals(shmTry(sprintf(nil
             "fallTime(%s %g nil 0 nil %d %d t \"cycle\")" shmV(y) shmVdd shmLo shmHi)))
    ;; (thetas are % of the transition from initVal, so 10 90 = 0.9*VDD -> 0.1*VDD)
    tpd  = shmDelays(shmCross(y shmHalf))
    shmEdges   = shmEdges + length(tpd)
    shmAllRise = append(shmAllRise rise)
    shmAllFall = append(shmAllFall fall)
    shmAllTpd  = append(shmAllTpd tpd)
    shmRows = cons(list(y shmMax(rise) shmAvg(rise) shmMax(fall) shmAvg(fall)
                        shmMax(tpd) shmAvg(tpd) length(tpd)) shmRows)))
shmRows = reverse(shmRows)

;; Power, first method that yields a waveform:
;;   1. IT(DUT/VDD) * VDD       2. any saved current named <DUT>:VDD / <DUT>/VDD
;;   3. Spectre <DUT>:pwr       4. Spectre total :pwr
procedure(shmIsWave(w) w && drIsWaveform(w))
shmP = nil  shmPwrSrc = nil
let((w)
  w = shmTry(sprintf(nil "IT(\"%s/VDD\")" shmDut))
  when(shmIsWave(w) shmP = w * shmVdd  shmPwrSrc = sprintf(nil "IT(%s/VDD) * VDD" shmDut)))
unless(shmP
  let((pat w)
    pat = upperCase(sprintf(nil "^/?%s[:/]VDD$" shmDutName))
    foreach(name car(errset(outputs()))
      when(!shmP && stringp(name) && rexMatchp(pat upperCase(name))
        w = shmTry(sprintf(nil "getData(\"%s\")" name))
        when(shmIsWave(w) shmP = w * shmVdd  shmPwrSrc = strcat(name " * VDD"))))))
foreach(name list(strcat(shmDutName ":pwr") ":pwr")
  unless(shmP
    let((w) w = shmTry(sprintf(nil "getData(\"%s\")" name))
      when(shmIsWave(w) shmP = w  shmPwrSrc = strcat("Spectre " name))))))
unless(shmP
  error("No supply current or power signal found for %s. Check shmDut is the DUT \
instance and rerun with shmRunSim = t. Saved signals: %L\n" shmDut errset(outputs())))
printf("Power measured from %s\n" shmPwrSrc)
;; Current is positive into the terminal, but flip if the sign convention differs.
when(average(shmP) < 0 shmP = -1 * shmP)
shmPavg   = average(shmP)
shmPpeak  = ymax(shmP)
shmEnergy = integ(shmP)

;; ---------------------------------------------------------------- report
shmHdr = "net,rise_max_ps,rise_avg_ps,fall_max_ps,fall_avg_ps,tpd_max_ps,tpd_avg_ps,edges"
printf("\n=== Shifter_8bit_sized %s metrics  (VDD = %.3f V, slew %d-%d%%) ===\n"
       if(shmPexNetlist "post-layout" "schematic") shmVdd shmLo shmHi)
printf("%-5s %10s %10s %10s %10s %10s %10s %6s\n"
       "net" "rise max" "rise avg" "fall max" "fall avg" "tpd max" "tpd avg" "edges")
shmPort = outfile(shmCsv)
fprintf(shmPort "%s\n" shmHdr)
foreach(r append(shmRows
                 list(list("ALL" shmMax(shmAllRise) shmAvg(shmAllRise)
                           shmMax(shmAllFall) shmAvg(shmAllFall)
                           shmMax(shmAllTpd) shmAvg(shmAllTpd) shmEdges)))
  let((cells)
    cells = mapcar(lambda((x) shmFmt(x 1e12)) list(nthelem(2 r) nthelem(3 r) nthelem(4 r)
                                                  nthelem(5 r) nthelem(6 r) nthelem(7 r)))
    printf("%-5s %10s %10s %10s %10s %10s %10s %6d\n"
           car(r) nth(0 cells) nth(1 cells) nth(2 cells) nth(3 cells) nth(4 cells)
           nth(5 cells) nthelem(8 r))
    fprintf(shmPort "%s,%s,%s,%s,%s,%s,%s,%d\n" car(r) nth(0 cells) nth(1 cells)
            nth(2 cells) nth(3 cells) nth(4 cells) nth(5 cells) nthelem(8 r))))
printf("(times in ps)\n\n")
printf("Power   avg  = %.3f uW\n" shmPavg * 1e6)
printf("Power   peak = %.3f uW\n" shmPpeak * 1e6)
printf("Energy  total= %.3f pJ over %g s\n" shmEnergy * 1e12 shmStop)
when(shmEdges > 0
  printf("Energy / output edge = %.3f fJ\n" shmEnergy * 1e15 / shmEdges))
fprintf(shmPort "\nmetric,value\n")
fprintf(shmPort "power_source,%s\n" shmPwrSrc)
fprintf(shmPort "mode,%s\n" if(shmPexNetlist "post-layout" "schematic"))
fprintf(shmPort "vdd_V,%.4f\npower_avg_uW,%.4f\npower_peak_uW,%.4f\nenergy_pJ,%.4f\n"
        shmVdd shmPavg*1e6 shmPpeak*1e6 shmEnergy*1e12)
close(shmPort)
printf("Wrote %s\n" shmCsv)
